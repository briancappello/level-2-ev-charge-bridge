* EMG IN loop, J4.11 (CB-EVAL LevelShiftInput2 + R1, R2a || R2b)
V24 vp 0 26.4
Rchain vp a 1000000000000.0
R1 a emg 2222.0
R2a emg 0 2222.0
R2b emg 0 1000000000000.0
R9 vp emg 101000.0
R43 emg x 20200.0
R76 x 0 1010000.0
D22 0 x DZ
Rsw2 emg 0 1000000000000.0
.model DZ D(IS=1e-14 N=1 RS=20 BV=5.1 IBV=1m)
.control
op
print v(emg) v(x) v(a)
.endc
.end
