* Relay 1 feedback, J5.12 (CB-EVAL LevelShiftInput7 + R3 + K1 aux 21-22)
Vs vp 0 3.3
Rsrc vp s 330
Vam s s2 0
Raux s2 fb 1000000000000.0
R3 fb 0 1000000000000.0
R68 fb x 20000.0
R97 x 0 1000000.0
D32 0 x DZ
.model DZ D(IS=1e-14 N=1 RS=20 BV=5.1 IBV=1m)
.control
op
print v(fb) v(x) v(s) i(vam)
.endc
.end
