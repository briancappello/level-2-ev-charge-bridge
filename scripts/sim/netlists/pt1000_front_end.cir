* PT1000_1 front end (R91, R70, R89, R90, U11 INA333 with Rg = R92)
.param rpt=1000
Vref ref 0 2.048
R91 ref p 4990
Rpt p m {rpt}
R70 m 0 4990
R89 ref n 4990
R90 n m 825
* INA333 as an ideal difference amplifier, output limited to the 0-3.3 V rails
Bina out 0 V = max(0, min(3.3, 30.069767441860463 * (v(p) - v(n))))
Rload out 0 100k
.control
foreach val 842.744 862.502 882.231 901.932 921.603 941.246 960.859 980.444 1000.000 1019.527 1039.025 1058.495 1077.935 1097.347 1116.729 1136.083 1155.408 1174.704 1193.971 1213.210 1232.419 1251.600 1270.751 1289.874 1308.968 1328.033 1347.069 1366.077 1385.055 1404.005 1422.925 1441.817 1460.680 1479.514 1498.319 1517.096 1535.843 1554.562 1573.251 1591.912 1610.544 1629.147 1647.721 1666.267 1684.783
  alterparam rpt = $val
  reset
  op
  print v(out)
end
.endc
.end
